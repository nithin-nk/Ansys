# Ansys Electronics Desktop project, version 2023.1
materials:
  vacuum: permittivity=1

design HFSSDesign1 (HFSS, HFSS Modal Network, model units mm)
geometry:
  Box1 [vacuum] = box(corner=(0mm, 0mm, 0mm), size=(0.42in, 0.17in, 0.4mm))
  E_Plane_Tee1 = component(E_Plane_Tee, 3D_Component_File_Path="<syslib>/3DComponents/HFSS/Rectangular Waveguide/E_Plane_Tee.a3dcomp", FlangeThickness=0.2in, GuideHeight=0.4in, Flange=0.4in, WallThickness=0.1in, GuideWidth=0.9in, FlangeFillet=0.2in, GuideLength=2in)
  EPT_Interior [vacuum] = part_of(E_Plane_Tee1)
  EPT [aluminum] = part_of(E_Plane_Tee1)
  H_Plane_Tee1 = component(H_Plane_Tee, 3D_Component_File_Path="<syslib>/3DComponents/HFSS/Rectangular Waveguide/H_Plane_Tee.a3dcomp", FlangeThickness=0.2in, GuideHeight=0.4in, Flange=0.4in, WallThickness=0.1in, GuideWidth=0.9in, FlangeFillet=0.2in, GuideLength=2in)
  HPT_Interior [vacuum] = part_of(H_Plane_Tee1)
  HPT [aluminum] = part_of(H_Plane_Tee1)
  H_Plane_Tee1.rotate(RotateAxis=Y RotateAngle=180deg)
  Rectangle1 = rectangle(corner=(11.43mm, 50.8mm, 55.88mm), z_size=-10.16mm, x_size=-22.86mm)
  Rectangle2 = rectangle(corner=(11.43mm, 50.8mm, 55.88mm), z_size=-10.16mm, x_size=-22.86mm)
  Rectangle3 = rectangle(corner=(11.43mm, 50.8mm, 45.72mm), z_size=10.16mm, x_size=-22.86mm)
  Rectangle4 = rectangle(corner=(-11.43mm, -50.8mm, 45.72mm), z_size=10.16mm, x_size=22.86mm)
  Rectangle5 = rectangle(corner=(50.8mm, 5.08mm, -62.23mm), y_size=-10.16mm, z_size=22.86mm)
  Rectangle6 = rectangle(corner=(-50.8mm, 5.08mm, -39.37mm), y_size=-10.16mm, z_size=-22.86mm)
boundaries and excitations:
  1: Wave Port Objects=Rectangle3 WavePortType=Default NumModes=1 Modes{Mode1{IntLine{(0, 50.8, 45.72) -> (0, 50.8, 55.88)} CharImp=Zpi}}
  2: Wave Port Objects=Rectangle4 WavePortType=Default NumModes=1 Modes{Mode1{IntLine{(0, -50.8, 55.88) -> (0, -50.8, 45.72)} CharImp=Zpi}}
  3: Wave Port Objects=Rectangle5 WavePortType=Default NumModes=1 Modes{Mode1{IntLine{(50.8, 5.08, -50.8) -> (50.8, -5.08, -50.8)} CharImp=Zpi}}
  4: Wave Port Objects=Rectangle6 WavePortType=Default NumModes=1 Modes{Mode1{IntLine{(-50.8, 5.08, -50.8) -> (-50.8, -5.08, -50.8)} CharImp=Zpi}}
setups:
  Setup1: HfssDriven Frequency=25GHz MaxDeltaS=0.02 MaximumPasses=6 MinimumPasses=1 MinimumConvergedPasses=1 PercentRefinement=30 BasisOrder=1 PortAccuracy=2 DrivenSolverType="Direct Solver"
    sweep Sweep: 18GHz to 26.5GHz, 101 points; Type=Interpolating SaveFields InterpTolerance=0.5 InterpMaxSolns=250 InterpUsePortImped=false PassivityErrorTolerance=0.0001
source amplitudes:
  1:1: 1W 0deg
  2:1, 3:1, 4:1: 0W 0deg
field plots:
  Mag_E1: E Field on Setup1 : LastAdaptive at Freq=25GHz Phase=0deg
