# Ansys Electronics Desktop project, version 2023.1
materials:
  vacuum: permittivity=1
  FR4_epoxy: permittivity=4.4 dielectric_loss_tangent=0.02
  PMLGroup1_Z_1: permittivity{anisotropic component1=1.3053984 component2=1.3053984 component3=0.38302483} permeability{anisotropic component1=1.3053984 component2=1.3053984 component3=0.38302483} dielectric_loss_tangent{anisotropic component1=1 component2=1 component3=-1} magnetic_loss_tangent{anisotropic component1=1 component2=1 component3=-1}
  PMLGroup1_XZ_1: permittivity{anisotropic component1=1 component2=0.01 component3=1} permeability{anisotropic component1=1 component2=0.01 component3=1} dielectric_loss_tangent{anisotropic component1=0 component2=340.813 component3=0} magnetic_loss_tangent{anisotropic component1=0 component2=340.813 component3=0}
  PMLGroup1_YZ_1: permittivity{anisotropic component1=0.01 component2=1 component3=1} permeability{anisotropic component1=0.01 component2=1 component3=1} dielectric_loss_tangent{anisotropic component1=340.813 component2=0 component3=0} magnetic_loss_tangent{anisotropic component1=340.813 component2=0 component3=0}
  PMLGroup1_XYZ_1: permittivity{anisotropic component1=1.3053984 component2=1.3053984 component3=1.3053984} permeability{anisotropic component1=1.3053984 component2=1.3053984 component3=1.3053984} dielectric_loss_tangent{anisotropic component1=1 component2=1 component3=1} magnetic_loss_tangent{anisotropic component1=1 component2=1 component3=1}

design HFSSDesign1 (HFSS, HFSS Terminal Network, model units mm)
variables:
  Wsub = 10mm
geometry:
  Box1 [FR4_epoxy] = box(corner=(0mm, 0mm, 0mm), size=(10mm, 68mm, 1.6mm))
  Rectangle1 = rectangle(corner=(3.5mm, 0mm, 1.6mm), x_size=3.05mm, y_size=68mm)
  Rectangle2 = rectangle(corner=(6.55mm, 68mm, 1.6mm), z_size=-1.6mm, x_size=-3.04mm)
  Rectangle3 = rectangle(corner=(3.5mm, 0mm, 1.6mm), z_size=-1.6mm, x_size=3.04mm)
  RadiatingSurface [vacuum] = region(absolute_offset=31.25mm on all sides)
  coordinate_system FaceCS1 = face of RadiatingSurface: Origin=(41.25, -31.25, 32.85) FaceID=RadiatingSurface.face(+z) AxisPosn=(41.25, 99.25, 32.85) WhichAxis=X ZRotationAngle=0deg XOffset=0mm YOffset=0mm FaceNormal(0, 0, 1)
  PML_RadiatingSurface_1 [PMLGroup1_Z_1, oriented by FaceCS1] = sweep_along_normal(RadiatingSurface.face(+z), length=42.816724mm)
  coordinate_system FaceCS2 = face of RadiatingSurface: Origin=(41.25, -31.25, -31.25) FaceID=RadiatingSurface.face(-z) AxisPosn=(-31.25, -31.25, -31.25) WhichAxis=X ZRotationAngle=0deg XOffset=0mm YOffset=0mm FaceNormal(0, 0, -1)
  PML_RadiatingSurface_2 [PMLGroup1_Z_1, oriented by FaceCS2] = sweep_along_normal(RadiatingSurface.face(-z), length=42.816724mm)
  coordinate_system FaceCS3 = face of RadiatingSurface: Origin=(41.25, -31.25, 32.85) FaceID=RadiatingSurface.face(-y) AxisPosn=(-31.25, -31.25, 32.85) WhichAxis=X ZRotationAngle=0deg XOffset=0mm YOffset=0mm FaceNormal(0, -1, 0)
  PML_RadiatingSurface_3 [PMLGroup1_Z_1, oriented by FaceCS3] = sweep_along_normal(RadiatingSurface.face(-y), length=42.816724mm)
  coordinate_system FaceCS4 = face of RadiatingSurface: Origin=(-31.25, -31.25, 32.85) FaceID=RadiatingSurface.face(-x) AxisPosn=(-31.25, 99.25, 32.85) WhichAxis=X ZRotationAngle=0deg XOffset=0mm YOffset=0mm FaceNormal(-1, 0, 0)
  PML_RadiatingSurface_4 [PMLGroup1_Z_1, oriented by FaceCS4] = sweep_along_normal(RadiatingSurface.face(-x), length=42.816724mm)
  coordinate_system FaceCS5 = face of RadiatingSurface: Origin=(-31.25, 99.25, 32.85) FaceID=RadiatingSurface.face(+y) AxisPosn=(41.25, 99.25, 32.85) WhichAxis=X ZRotationAngle=0deg XOffset=0mm YOffset=0mm FaceNormal(0, 1, 0)
  PML_RadiatingSurface_5 [PMLGroup1_Z_1, oriented by FaceCS5] = sweep_along_normal(RadiatingSurface.face(+y), length=42.816724mm)
  coordinate_system FaceCS6 = face of RadiatingSurface: Origin=(41.25, 99.25, -31.25) FaceID=RadiatingSurface.face(+x) AxisPosn=(41.25, 99.25, 32.85) WhichAxis=X ZRotationAngle=0deg XOffset=0mm YOffset=0mm FaceNormal(1, 0, 0)
  PML_RadiatingSurface_6 [PMLGroup1_Z_1, oriented by FaceCS6] = sweep_along_normal(RadiatingSurface.face(+x), length=42.816724mm)
  PML_RadiatingSurface_7 [PMLGroup1_XZ_1, oriented by FaceCS1] = sweep_along_normal(PML_RadiatingSurface_1.face(at (5, -31.25, 54.2584)), length=42.816724mm)
  PML_RadiatingSurface_8 [PMLGroup1_YZ_1, oriented by FaceCS4] = sweep_along_normal(PML_RadiatingSurface_1.face(at (-31.25, 34, 54.2584)), length=42.816724mm)
  PML_RadiatingSurface_9 [PMLGroup1_YZ_1, oriented by FaceCS5] = sweep_along_normal(PML_RadiatingSurface_1.face(at (5, 99.25, 54.2584)), length=42.816724mm)
  PML_RadiatingSurface_10 [PMLGroup1_YZ_1, oriented by FaceCS1] = sweep_along_normal(PML_RadiatingSurface_1.face(at (41.25, 34, 54.2584)), length=42.816724mm)
  PML_RadiatingSurface_11 [PMLGroup1_YZ_1, oriented by FaceCS2] = sweep_along_normal(PML_RadiatingSurface_2.face(at (5, -31.25, -52.6584)), length=42.816724mm)
  coordinate_system FaceCS7 = face of RadiatingSurface: Origin=(-31.25, -31.25, -31.25) FaceID=RadiatingSurface.face(-z) AxisPosn=(-31.25, 99.25, -31.25) WhichAxis=X ZRotationAngle=0deg XOffset=0mm YOffset=0mm FaceNormal(0, 0, -1)
  PML_RadiatingSurface_12 [PMLGroup1_YZ_1, oriented by FaceCS7] = sweep_along_normal(PML_RadiatingSurface_2.face(at (-31.25, 34, -52.6584)), length=42.816724mm)
  coordinate_system FaceCS8 = face of RadiatingSurface: Origin=(-31.25, 99.25, -31.25) FaceID=RadiatingSurface.face(-z) AxisPosn=(41.25, 99.25, -31.25) WhichAxis=X ZRotationAngle=0deg XOffset=0mm YOffset=0mm FaceNormal(0, 0, -1)
  PML_RadiatingSurface_13 [PMLGroup1_YZ_1, oriented by FaceCS8] = sweep_along_normal(PML_RadiatingSurface_2.face(at (5, 99.25, -52.6584)), length=42.816724mm)
  PML_RadiatingSurface_14 [PMLGroup1_XZ_1, oriented by FaceCS2] = sweep_along_normal(PML_RadiatingSurface_2.face(at (41.25, 34, -52.6584)), length=42.816724mm)
  PML_RadiatingSurface_15 [PMLGroup1_XZ_1, oriented by FaceCS4] = sweep_along_normal(PML_RadiatingSurface_3.face(at (-31.25, -52.6584, 0.8)), length=42.816724mm)
  PML_RadiatingSurface_16 [PMLGroup1_XZ_1, oriented by FaceCS3] = sweep_along_normal(PML_RadiatingSurface_3.face(at (41.25, -52.6584, 0.8)), length=42.816724mm)
  PML_RadiatingSurface_17 [PMLGroup1_XZ_1, oriented by FaceCS5] = sweep_along_normal(PML_RadiatingSurface_4.face(at (-52.6584, 99.25, 0.8)), length=42.816724mm)
  PML_RadiatingSurface_18 [PMLGroup1_YZ_1, oriented by FaceCS6] = sweep_along_normal(PML_RadiatingSurface_5.face(at (41.25, 120.658, 0.8)), length=42.816724mm)
  PML_RadiatingSurface_19 [PMLGroup1_XYZ_1, oriented by FaceCS4] = sweep_along_normal(PML_RadiatingSurface_7.face(at (-31.25, -52.6584, 54.2584)), length=42.816724mm)
  PML_RadiatingSurface_20 [PMLGroup1_XYZ_1, oriented by FaceCS1] = sweep_along_normal(PML_RadiatingSurface_7.face(at (41.25, -52.6584, 54.2584)), length=42.816724mm)
  PML_RadiatingSurface_21 [PMLGroup1_XYZ_1, oriented by FaceCS5] = sweep_along_normal(PML_RadiatingSurface_8.face(at (-52.6584, 99.25, 54.2584)), length=42.816724mm)
  coordinate_system FaceCS9 = face of RadiatingSurface: Origin=(41.25, 99.25, 32.85) FaceID=RadiatingSurface.face(+z) AxisPosn=(-31.25, 99.25, 32.85) WhichAxis=X ZRotationAngle=0deg XOffset=0mm YOffset=0mm FaceNormal(0, 0, 1)
  PML_RadiatingSurface_22 [PMLGroup1_XYZ_1, oriented by FaceCS9] = sweep_along_normal(PML_RadiatingSurface_9.face(at (41.25, 120.658, 54.2584)), length=42.816724mm)
  PML_RadiatingSurface_23 [PMLGroup1_XYZ_1, oriented by FaceCS7] = sweep_along_normal(PML_RadiatingSurface_11.face(at (-31.25, -52.6584, -52.6584)), length=42.816724mm)
  PML_RadiatingSurface_24 [PMLGroup1_XYZ_1, oriented by FaceCS2] = sweep_along_normal(PML_RadiatingSurface_11.face(at (41.25, -52.6584, -52.6584)), length=42.816724mm)
  PML_RadiatingSurface_25 [PMLGroup1_XYZ_1, oriented by FaceCS8] = sweep_along_normal(PML_RadiatingSurface_12.face(at (-52.6584, 99.25, -52.6584)), length=42.816724mm)
  PML_RadiatingSurface_26 [PMLGroup1_XYZ_1, oriented by FaceCS6] = sweep_along_normal(PML_RadiatingSurface_13.face(at (41.25, 120.658, -52.6584)), length=42.816724mm)
  Rectangle4 = rectangle(corner=((10/2)-(3.04/2) mm, 0mm, 1.6mm), x_size=2mm, y_size=68mm)
  group PMLGroup1 = PML_RadiatingSurface_1..PML_RadiatingSurface_26
boundaries and excitations:
  PerfE1: Perfect E Faces=Box1.face(-z)
  PerfE2: Perfect E Faces=Rectangle1.face
  PML_radiation1: Radiation Faces=RadiatingSurface.face(+z) IsForPML
  PML_radiation2: Radiation Faces=RadiatingSurface.face(-z) IsForPML
  PML_radiation3: Radiation Faces=RadiatingSurface.face(-y) IsForPML
  PML_radiation4: Radiation Faces=RadiatingSurface.face(-x) IsForPML
  PML_radiation5: Radiation Faces=RadiatingSurface.face(+y) IsForPML
  PML_radiation6: Radiation Faces=RadiatingSurface.face(+x) IsForPML
  1: Lumped Port Objects=Rectangle2 LumpedPortType=Modal Modes{Mode1{IntLine{(5.03, 68, 0) -> (5.03, 68, 1.6)} CharImp=Zpi}} Impedance=50ohm
  2: Lumped Port Faces=Rectangle3.face LumpedPortType=Modal Modes{Mode1{IntLine{(5.02, 0, 1.6) -> (5, 0, 0)} CharImp=Zpi}} Impedance=50ohm
setups:
  Setup1: HfssDriven Frequency=3.4GHz MaxDeltaS=0.02 MaximumPasses=6 MinimumPasses=1 MinimumConvergedPasses=1 PercentRefinement=30 BasisOrder=1 PortAccuracy=2 DrivenSolverType="Direct Solver"
    sweep Sweep: 1.7GHz to 5.1GHz, 401 points; Type=Interpolating InterpTolerance=0.5 InterpMaxSolns=250 PassivityErrorTolerance=0.0001
source amplitudes:
  1:1: 1V 0deg
  2:1: 0V 0deg
radiation setups:
  3D: Infinite Sphere Theta=0deg..180deg step 2deg Phi=-180deg..180deg step 2deg
  Elevation: Infinite Sphere Theta=-180deg..180deg step 1deg Phi=0deg..90deg step 90deg
  Azimuth: Infinite Sphere Theta=90deg..90deg step 0deg Phi=-180deg..180deg step 1deg
field plots:
  Mag_E1: E Field in Box1 on Setup1 : LastAdaptive at Freq=3.4GHz Phase=0deg
